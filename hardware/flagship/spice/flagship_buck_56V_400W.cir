* watt-forge flagship cross-check buck Vin=56.0 Vout=48.0 fs=75000.0
.model SWM SW(VT=0.5 VH=0 RON=1.493250e-03 ROFF=1e8)
VIN in 0 DC 56.0
VOUT out 0 DC 48.0
S1 in t1 g1 0 SWM
S2 t1 A g2 0 SWM
S3 A b1 g3 0 SWM
S4 b1 0 g4 0 SWM
RCF1 t1 cf1 7.500000e-04
CF1 cf1 b1 2.480000e-05 IC=2.768369752e+01
VG1 g1 0 PULSE(1 0 1.145252410e-05 1e-10 1e-10 1.880709230e-06 1.333333333e-05)
VG2 g2 0 PULSE(1 0 4.785857437e-06 1e-10 1e-10 1.880709230e-06 1.333333333e-05)
VG4 g4 0 PULSE(0 1 1.145252410e-05 1.000e-10 1.000e-10 1.880709230e-06 1.333333333e-05)
VG3 g3 0 PULSE(0 1 4.785857437e-06 1.000e-10 1.000e-10 1.880709230e-06 1.333333333e-05)
L1 A lx 4.700000e-06 IC=4.293146955e+00
RL lx B 4.161930e-03
S6 B t2 g6 0 SWM
S5 t2 out g5 0 SWM
S7 B b2 g7 0 SWM
S8 b2 0 g8 0 SWM
RCF2 t2 cf2 7.500000e-04
CF2 cf2 b2 2.656000e-05 IC=2.400000000e+01
VG5 g5 0 DC 1
VG6 g6 0 DC 1
VG7 g7 0 DC 0
VG8 g8 0 DC 0
.tran 6.666667e-09 5.333333e-04 0 3.333333e-09 uic
.meas tran pin AVG par('-v(in)*i(VIN)') FROM=4.000000000e-04 TO=5.333333333e-04
.meas tran pout AVG par('v(out)*i(VOUT)') FROM=4.000000000e-04 TO=5.333333333e-04
.meas tran ilavg AVG i(L1) FROM=4.000000000e-04 TO=5.333333333e-04
.end
